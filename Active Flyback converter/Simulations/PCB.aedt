# Ansys Electronics Desktop project, version 2023.1
materials:
  air: permittivity=1.0006
  copper: permeability=0.999991 conductivity=58000000
  FR4_epoxy: permittivity=4.4 dielectric_loss_tangent=0.02
  pec: permeability=1 conductivity=1e+30
  solder: permeability=1 conductivity=7000000
  ferrite: permittivity=12 permeability=1000 conductivity=0.01
  vacuum: permittivity=1

design Q3DModel1 (Q3D Extractor, model units mm)
options: Background_Material=air SParamCalcMethod=EqTransLine Allow_Material_Override Calculate_Lossy_Dielectrics
geometry:
  _primary_0.._primary_31, _secondary_0.._secondary_77, _primary_via_32.._primary_via_55, _secondary_via_78.._secondary_via_165, _primary_56, _primary_57, _secondary_166.._secondary_171, _primary_via_58.._primary_via_182, _secondary_via_172.._secondary_via_435 [copper] = imported_body()
  DIELECTRIC [FR4_epoxy] = imported_body()
  [_primary_0.._primary_31, _secondary_0.._secondary_77, _primary_via_32.._primary_via_55, _secondary_via_78.._secondary_via_165, _primary_56, _primary_57, _secondary_166.._secondary_171, _primary_via_58.._primary_via_182, _secondary_via_172.._secondary_via_435, DIELECTRIC].move(-97mm, 92mm, 0mm)
  Sweep1 [ferrite] = imported_body(C:\Users\akash\akash_github\PowerElectronics\Active Flyback converter\3D\toroid_core.STEP)
  Sweep1.rotate(axis=X, angle=90deg)
  Sweep1.move(20.45mm, 26.65mm, 0.85mm)
  Region [air] = region(percentage_offset=100 on all sides)
boundaries and excitations:
  net_primary: SignalNet Objects=[_primary_0.._primary_31, _primary_56, _primary_57, _primary_via_32.._primary_via_55, _primary_via_58.._primary_via_182]
  net_secondary: SignalNet Objects=[_secondary_0.._secondary_77, _secondary_166.._secondary_171, _secondary_via_78.._secondary_via_165, _secondary_via_172.._secondary_via_435]
  source_primary: Source Faces=_primary_8.face(at (18.6, 14.25, 1.66)) TerminalType=ConstantVoltage Net=net_primary
  sink_primary: Sink Faces=_primary_14.face(at (18.8, 40.95, 1.11)) TerminalType=ConstantVoltage Net=net_primary
mesh:
  initial mesh: MeshMethod=AnsoftClassic
setups:
  Setup1: Matrix AdaptiveFreq=250kHz SaveFields Cap{MaxPass=10 MinPass=1 MinConvPass=1 PerError=1 PerRefine=30 AutoIncreaseSolutionOrder SolutionOrder=High Solver_Type=Iterative} DC{Cond{MaxPass=10 MinPass=1 MinConvPass=1 PerError=1 PerRefine=30} Mult{MaxPass=1 MinPass=1 MinConvPass=1 PerError=1 PerRefine=30} Solution_Order=Normal} AC{MaxPass=10 MinPass=1 MinConvPass=1 PerError=1 PerRefine=30} ConstantDelta=0s ErrorValue=0.1
source amplitudes:
  net_primary:source_primary: AC 1A
  net_primary: Cap 1V 0deg
  net_secondary: Cap 0V 0deg
  net_primary:source_primary: DC 1A
